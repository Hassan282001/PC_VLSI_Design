ADE simulation setup
Run mode: Single Run, Sweeps and Corners
Tests:
  engg4550_TopMod_V2_1: engg4550/TopMod_V2/schematic, simulator spectre
