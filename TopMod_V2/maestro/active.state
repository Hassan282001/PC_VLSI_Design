ADE simulation setup
Test engg4550_TopMod_V2_1: engg4550/TopMod_V2/schematic, simulator spectre
  Models: /CMC_STC2/kits/cadence/GPDK045/gpdk045_v_6_0/gpdk045/../models/spectre/gpdk045.scs[mc]
  Temperature: 27
  Analysis tran: stop=64n
  Signals: /D_In<7:0>, /clk, /Sel, /increment<7:0>, /reset
Run mode: Single Run, Sweeps and Corners
